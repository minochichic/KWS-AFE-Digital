.title KiCad schematic - channel template
* 아래 모델 경로는 사용자 PC 환경에 맞게 수정할 수 있습니다.
.include "C:/Users/duyou/Desktop/Personal/10_Study/KiCAD/myLib/BAT54WT1.REV2.LIB"
.include "C:/Users/duyou/Desktop/Personal/10_Study/KiCAD/myLib/lpv7215/lpv7215.lib"
.include "C:/Users/duyou/Desktop/Personal/10_Study/KiCAD/myLib/op379/OPA379_PSPICE_AIO/OPA379.LIB"
.param RA=12.01k R1=56k R2=100k R4=10k R5=47k R6=8.25k R7=500k R8=500k
.param C1=7.59n C3=100n
XU2 Net-_U2-+_ Net-_U1--_ 1.8V GND Net-_C2-Pad1_ OPA379
V1 0.9V GND DC 0.9
RA2 Net-_U1--_ /v_filt_out {RA}
XU1 Net-_U1-+_ Net-_U1--_ 1.8v GND /v_filt_out OPA379
C2 Net-_C2-Pad1_ Net-_U1--_ {C1}
RA1 Net-_C2-Pad1_ Net-_U1-+_ {RA}
V2 1.8V 0.9V DC 0.9
R1 /vin Net-_U1-+_ {R1}
R3 0.9V Net-_U2-+_ {R2}
R6 0.9V Net-_U3-+_ {R6}
R5 Net-_D1-A_ /v_detect_out {R5}
D1 Net-_D1-A_ Net-_D1-K_ Dbat54wt1
XU3 Net-_U3-+_ Net-_D1-A_ 1.8V GND Net-_D1-K_ OPA379
R2 Net-_U2-+_ /v_filt_out {R2}
R4 /v_filt_out Net-_D1-A_ {R4}
D2 Net-_D1-K_ /v_detect_out Dbat54wt1
XU4 /v_detect_out /v_ref 1.8V GND /v_comp_out LPV7215
R8 GND /v_ref {R8}
C3 /v_detect_out GND {C3}
R7 /v_ref 1.8V {R7}
V3 Net-_V3-Pad1_ GND DC 0.9
V4 /vin Net-_V3-Pad1_ DC 0 SIN(0 1 1k 0 0 0) AC 1
C1 0.9V Net-_U1-+_ {C1}
.end
