.title v15 template localized (our OPA379 + .model BAT54 + behavioral comparator)
* Topology and node names IDENTICAL to ngspice_v15_2608001/netlist_template.cir.
* Only the model includes are localized so it runs on our ngspice.
.include ../models/OPA379.LIB
.model Dbat54wt1 D(Is=2.2n Rs=2 N=1.03 Cjo=10p M=0.4 Vj=0.4 Bv=30 Ibv=10u Eg=0.69 Xti=2)
.param RA=10.61k R1=53.4k R2=100k R4=10k R5=47k R6=8.25k R7=500k R8=500k
.param C1=1.86n C3=100n

XU2 Net-_U2-+_ Net-_U1--_ 1.8V GND Net-_C2-Pad1_ OPA379
R3 0.9V Net-_U2-+_ {R2}
R2 Net-_U2-+_ /v_filt {R2}
V2 1.8V 0.9V DC 0.9
V3 Net-_V3-Pad1_ GND DC 0.9
V1 0.9V GND DC 0.9
R6 0.9V Net-_U3-+_ {R6}
R4 /v_filt Net-_D1-A_ {R4}
R5 Net-_D1-A_ /v_env {R5}
D1 Net-_D1-A_ Net-_D1-K_ Dbat54wt1
XU3 Net-_U3-+_ Net-_D1-A_ 1.8V GND Net-_D1-K_ OPA379
D2 Net-_D1-K_ /v_env Dbat54wt1
R7 /v_thr 1.8V {R7}
R8 GND /v_thr {R8}
C3 /v_env GND {C3}
Bcomp /v_comp 0 V = 0.9 + 0.9*tanh(2e4*(v(/v_env) - v(/v_thr)))
RA2 Net-_U1--_ /v_filt {RA}
XU1 Net-_U1-+_ Net-_U1--_ 1.8v GND /v_filt OPA379
C2 Net-_C2-Pad1_ Net-_U1--_ {C1}
R1 /vin Net-_U1-+_ {R1}
C1 0.9V Net-_U1-+_ {C1}
RA1 Net-_C2-Pad1_ Net-_U1-+_ {RA}
V4 /vin Net-_V3-Pad1_ DC 0 SIN(0 10m 1k 0 0 0) AC 1
.end
