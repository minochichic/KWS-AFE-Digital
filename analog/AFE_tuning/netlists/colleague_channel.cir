.title colleague template (localized: our OPA379 + behavioral BAT54/LPV7215)
* Topology IDENTICAL to the colleague's netlist_template.cir; only the .include
* model paths are localized so it runs on our ngspice (BAT54 as a .model,
* LPV7215 as a behavioral comparator -- the vendor libs use PSpice syntax).
.include ../models/OPA379.LIB
.model Dbat54wt1 D(Is=2.2n Rs=2 N=1.03 Cjo=10p M=0.4 Vj=0.4 Bv=30 Ibv=10u Eg=0.69 Xti=2)
* 아래 모델 경로는 사용자 PC 환경에 맞게 수정할 수 있습니다.
.param RA=12.01k R1=56k R2=100k R4=10k R5=47k R6=8.25k R7=500k R8=500k
.param C1=7.59n C3=100n
XU2 Net-_U2-+_ Net-_U1--_ 1.8V GND Net-_C2-Pad1_ OPA379
V1 0.9V GND DC 0.9
RA2 Net-_U1--_ /v_filt_out {RA}
XU1 Net-_U1-+_ Net-_U1--_ 1.8v GND /v_filt_out OPA379
C2 Net-_C2-Pad1_ Net-_U1--_ {C1}
RA1 Net-_C2-Pad1_ Net-_U1-+_ {RA}
V2 1.8V 0.9V DC 0.9
R1 /vin Net-_U1-+_ {R1}
R3 0.9V Net-_U2-+_ {R2}
R6 0.9V Net-_U3-+_ {R6}
R5 Net-_D1-A_ /v_detect_out {R5}
D1 Net-_D1-A_ Net-_D1-K_ Dbat54wt1
XU3 Net-_U3-+_ Net-_D1-A_ 1.8V GND Net-_D1-K_ OPA379
R2 Net-_U2-+_ /v_filt_out {R2}
R4 /v_filt_out Net-_D1-A_ {R4}
D2 Net-_D1-K_ /v_detect_out Dbat54wt1
Bcomp /v_comp_out 0 V = 0.9 + 0.9*tanh(2e4*(v(/v_detect_out) - v(/v_ref)))
R8 GND /v_ref {R8}
C3 /v_detect_out GND {C3}
R7 /v_ref 1.8V {R7}
V3 Net-_V3-Pad1_ GND DC 0.9
V4 /vin Net-_V3-Pad1_ DC 0 SIN(0 1 1k 0 0 0) AC 1
C1 0.9V Net-_U1-+_ {C1}
.end
