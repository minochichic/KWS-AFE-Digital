.title AFE 16ch -- diode-OR soft-max threshold (xlse), delta = 0
* Generated by analog/AFE/scripts/gen_afe16.py -- do not hand-edit.
* Per-channel chain identical to AFE_tuning/netlists/v15_channel.cir.
* New vs the existing board: the comparator reference only (see below).

.include ../models/OPA379.LIB
* BAT54 as a 2-terminal .model: the vendor subckt carries a parametric
* 'mfg=' that ngspice rejects. Same params the verified netlists use.
.model Dbat54wt1 D(Is=2.2n Rs=2 N=1.03 Cjo=10p M=0.4 Vj=0.4 Bv=30
+ Ibv=10u Eg=0.69 Xti=2)

* ---- supplies -------------------------------------------------------
Vpos  vpos  0  DC 1.8
Vmid  vmid  0  DC 0.9        $ bias rail

* ---- microphone + preamp (G = 1 + Rf/Rg = 10) -----------------------
* Tone BURST (on 20-60 ms, off after) so the transient shows both the
* attack and the decay. u() is ngspice's unit step.
Bmic  vmic  vmid  V = 0.00252*sin(6.283185307*1349*time)
+ *(u(time-20m)-u(time-60m))
XUPRE vmic  npre  vpos 0 vin  OPA379
Rf    vin   npre  90k
Rg    npre  vmid  10k

* ---- shared threshold generator (THE NEW PART) ----------------------
* xmax variant: an IDEAL max(), which is what the diode-OR would be
* if n*V_T were zero. Not buildable as written -- it exists to isolate
* what the LSE floor T*ln(16) is worth. See SPICE_FINDINGS.md 2.
Bmax  v_max 0  V = max(max(max(max(max(max(max(max(max(max(max(max(max(max(max(v(ve0),v(ve1)),v(ve2)),v(ve3)),v(ve4)),v(ve5)),v(ve6)),v(ve7)),v(ve8)),v(ve9)),v(ve10)),v(ve11)),v(ve12)),v(ve13)),v(ve14)),v(ve15))

* C) V_ref, the low end of every divider. Training fixes it at the
*    envelope quiescent, i.e. delta = 0 (docs/EXPERIMENT_MAP.md A-3).
*
*    Kept as an ideal source on purpose, so delta is one sweepable knob
*    here exactly as floor_frac is in training. On the board it is a
*    divider off the 1.8 V rail through a unity-gain OPA379; the buffer
*    is NOT optional, because at quiescent D2 is reverse biased and the
*    envelope node is high impedance -- unbuffered, the 16 dividers drew
*    ~0.9 uA and moved the reference 40 mV.
*
*    A replica detector was tried first and does not work. Its R4 has to
*    sit at the filter output DC level, not at vmid, and that level is
*    itself 2 op-amp offsets below vmid. Worse, the quiescent envelope is
*    da + (R5/R4)*(vf - da): each channel's own offset, amplified 4.7x,
*    random per device. Nothing passive tracks that, so a replica buys
*    less than it costs (3 op-amps) and this is a bring-up trim instead.
.param VREFSET=0.9183840   $ delta = +0.0 mV
Vref  v_ref 0  DC {VREFSET}

* ==== channel 0: f_c 166 Hz, Q 1.33, alpha 0.8745 ====
R1_0   vin    np0   16.5064k
C1_0   vmid   np0   76.5554n
RA1_0  c2p0 np0   12.3353k
XU1_0  np0  nn0   vpos 0 vf0  OPA379
C2_0   c2p0 nn0   76.5554n
RA2_0  nn0  vf0   12.3353k
R2_0   nu20 vf0   100k
R3_0   vmid   nu20  100k
XU2_0  nu20 nn0   vpos 0 c2p0  OPA379
R4_0   vf0  da0   10k
R5_0   da0  ve0   47k
R6_0   vmid   np30  8.25k
D1_0   da0  dk0   Dbat54wt1
XU3_0  np30 da0   vpos 0 dk0  OPA379
D2_0   dk0  ve0   Dbat54wt1
C3_0   ve0  0       100n
DOR_0  ve0  v_or    Dbat54wt1
Ra_0   v_max  vt0   125.5000k
Rb_0   vt0  v_ref   874.5000k
Bcmp_0 vo0  0  V = 0.9 + 0.9*tanh(2e4*(v(ve0) - v(vt0)))

* ==== channel 1: f_c 295 Hz, Q 2.08, alpha 0.7804 ====
R1_1   vin    np1   26.1343k
C1_1   vmid   np1   42.3465n
RA1_1  c2p1 np1   12.5026k
XU1_1  np1  nn1   vpos 0 vf1  OPA379
C2_1   c2p1 nn1   42.3465n
RA2_1  nn1  vf1   12.5026k
R2_1   nu21 vf1   100k
R3_1   vmid   nu21  100k
XU2_1  nu21 nn1   vpos 0 c2p1  OPA379
R4_1   vf1  da1   10k
R5_1   da1  ve1   47k
R6_1   vmid   np31  8.25k
D1_1   da1  dk1   Dbat54wt1
XU3_1  np31 da1   vpos 0 dk1  OPA379
D2_1   dk1  ve1   Dbat54wt1
C3_1   ve1  0       100n
DOR_1  ve1  v_or    Dbat54wt1
Ra_1   v_max  vt1   219.6000k
Rb_1   vt1  v_ref   780.4000k
Bcmp_1 vo1  0  V = 0.9 + 0.9*tanh(2e4*(v(ve1) - v(vt1)))

* ==== channel 2: f_c 447 Hz, Q 2.73, alpha 0.4788 ====
R1_2   vin    np2   34.1241k
C1_2   vmid   np2   27.9302n
RA1_2  c2p2 np2   12.4798k
XU1_2  np2  nn2   vpos 0 vf2  OPA379
C2_2   c2p2 nn2   27.9302n
RA2_2  nn2  vf2   12.4798k
R2_2   nu22 vf2   100k
R3_2   vmid   nu22  100k
XU2_2  nu22 nn2   vpos 0 c2p2  OPA379
R4_2   vf2  da2   10k
R5_2   da2  ve2   47k
R6_2   vmid   np32  8.25k
D1_2   da2  dk2   Dbat54wt1
XU3_2  np32 da2   vpos 0 dk2  OPA379
D2_2   dk2  ve2   Dbat54wt1
C3_2   ve2  0       100n
DOR_2  ve2  v_or    Dbat54wt1
Ra_2   v_max  vt2   521.2000k
Rb_2   vt2  v_ref   478.8000k
Bcmp_2 vo2  0  V = 0.9 + 0.9*tanh(2e4*(v(ve2) - v(vt2)))

* ==== channel 3: f_c 631 Hz, Q 3.29, alpha 0.4482 ====
R1_3   vin    np3   40.1907k
C1_3   vmid   np3   20.0471n
RA1_3  c2p3 np3   12.2556k
XU1_3  np3  nn3   vpos 0 vf3  OPA379
C2_3   c2p3 nn3   20.0471n
RA2_3  nn3  vf3   12.2556k
R2_3   nu23 vf3   100k
R3_3   vmid   nu23  100k
XU2_3  nu23 nn3   vpos 0 c2p3  OPA379
R4_3   vf3  da3   10k
R5_3   da3  ve3   47k
R6_3   vmid   np33  8.25k
D1_3   da3  dk3   Dbat54wt1
XU3_3  np33 da3   vpos 0 dk3  OPA379
D2_3   dk3  ve3   Dbat54wt1
C3_3   ve3  0       100n
DOR_3  ve3  v_or    Dbat54wt1
Ra_3   v_max  vt3   551.8000k
Rb_3   vt3  v_ref   448.2000k
Bcmp_3 vo3  0  V = 0.9 + 0.9*tanh(2e4*(v(ve3) - v(vt3)))

* ==== channel 4: f_c 832 Hz, Q 3.77, alpha 0.5423 ====
R1_4   vin    np4   45.8726k
C1_4   vmid   np4   15.1182n
RA1_4  c2p4 np4   12.2699k
XU1_4  np4  nn4   vpos 0 vf4  OPA379
C2_4   c2p4 nn4   15.1182n
RA2_4  nn4  vf4   12.2699k
R2_4   nu24 vf4   100k
R3_4   vmid   nu24  100k
XU2_4  nu24 nn4   vpos 0 c2p4  OPA379
R4_4   vf4  da4   10k
R5_4   da4  ve4   47k
R6_4   vmid   np34  8.25k
D1_4   da4  dk4   Dbat54wt1
XU3_4  np34 da4   vpos 0 dk4  OPA379
D2_4   dk4  ve4   Dbat54wt1
C3_4   ve4  0       100n
DOR_4  ve4  v_or    Dbat54wt1
Ra_4   v_max  vt4   457.7000k
Rb_4   vt4  v_ref   542.3000k
Bcmp_4 vo4  0  V = 0.9 + 0.9*tanh(2e4*(v(ve4) - v(vt4)))

* ==== channel 5: f_c 1072 Hz, Q 4.20, alpha 0.4072 ====
R1_5   vin    np5   50.0495k
C1_5   vmid   np5   11.7744n
RA1_5  c2p5 np5   12.1601k
XU1_5  np5  nn5   vpos 0 vf5  OPA379
C2_5   c2p5 nn5   11.7744n
RA2_5  nn5  vf5   12.1601k
R2_5   nu25 vf5   100k
R3_5   vmid   nu25  100k
XU2_5  nu25 nn5   vpos 0 c2p5  OPA379
R4_5   vf5  da5   10k
R5_5   da5  ve5   47k
R6_5   vmid   np35  8.25k
D1_5   da5  dk5   Dbat54wt1
XU3_5  np35 da5   vpos 0 dk5  OPA379
D2_5   dk5  ve5   Dbat54wt1
C3_5   ve5  0       100n
DOR_5  ve5  v_or    Dbat54wt1
Ra_5   v_max  vt5   592.8000k
Rb_5   vt5  v_ref   407.2000k
Bcmp_5 vo5  0  V = 0.9 + 0.9*tanh(2e4*(v(ve5) - v(vt5)))

* ==== channel 6: f_c 1349 Hz, Q 4.56, alpha 0.1725 ====
R1_6   vin    np6   53.2712k
C1_6   vmid   np6   9.3784n
RA1_6  c2p6 np6   12.0473k
XU1_6  np6  nn6   vpos 0 vf6  OPA379
C2_6   c2p6 nn6   9.3784n
RA2_6  nn6  vf6   12.0473k
R2_6   nu26 vf6   100k
R3_6   vmid   nu26  100k
XU2_6  nu26 nn6   vpos 0 c2p6  OPA379
R4_6   vf6  da6   10k
R5_6   da6  ve6   47k
R6_6   vmid   np36  8.25k
D1_6   da6  dk6   Dbat54wt1
XU3_6  np36 da6   vpos 0 dk6  OPA379
D2_6   dk6  ve6   Dbat54wt1
C3_6   ve6  0       100n
DOR_6  ve6  v_or    Dbat54wt1
Ra_6   v_max  vt6   827.5000k
Rb_6   vt6  v_ref   172.5000k
Bcmp_6 vo6  0  V = 0.9 + 0.9*tanh(2e4*(v(ve6) - v(vt6)))

* ==== channel 7: f_c 1660 Hz, Q 4.88, alpha 0.1326 ====
R1_7   vin    np7   55.9883k
C1_7   vmid   np7   7.5935n
RA1_7  c2p7 np7   12.0057k
XU1_7  np7  nn7   vpos 0 vf7  OPA379
C2_7   c2p7 nn7   7.5935n
RA2_7  nn7  vf7   12.0057k
R2_7   nu27 vf7   100k
R3_7   vmid   nu27  100k
XU2_7  nu27 nn7   vpos 0 c2p7  OPA379
R4_7   vf7  da7   10k
R5_7   da7  ve7   47k
R6_7   vmid   np37  8.25k
D1_7   da7  dk7   Dbat54wt1
XU3_7  np37 da7   vpos 0 dk7  OPA379
D2_7   dk7  ve7   Dbat54wt1
C3_7   ve7  0       100n
DOR_7  ve7  v_or    Dbat54wt1
Ra_7   v_max  vt7   867.4000k
Rb_7   vt7  v_ref   132.6000k
Bcmp_7 vo7  0  V = 0.9 + 0.9*tanh(2e4*(v(ve7) - v(vt7)))

* ==== channel 8: f_c 2042 Hz, Q 5.15, alpha 0.1799 ====
R1_8   vin    np8   57.0802k
C1_8   vmid   np8   6.2250n
RA1_8  c2p8 np8   11.7952k
XU1_8  np8  nn8   vpos 0 vf8  OPA379
C2_8   c2p8 nn8   6.2250n
RA2_8  nn8  vf8   11.7952k
R2_8   nu28 vf8   100k
R3_8   vmid   nu28  100k
XU2_8  nu28 nn8   vpos 0 c2p8  OPA379
R4_8   vf8  da8   10k
R5_8   da8  ve8   47k
R6_8   vmid   np38  8.25k
D1_8   da8  dk8   Dbat54wt1
XU3_8  np38 da8   vpos 0 dk8  OPA379
D2_8   dk8  ve8   Dbat54wt1
C3_8   ve8  0       100n
DOR_8  ve8  v_or    Dbat54wt1
Ra_8   v_max  vt8   820.1000k
Rb_8   vt8  v_ref   179.9000k
Bcmp_8 vo8  0  V = 0.9 + 0.9*tanh(2e4*(v(ve8) - v(vt8)))

* ==== channel 9: f_c 2455 Hz, Q 5.39, alpha 0.1242 ====
R1_9   vin    np9   58.3727k
C1_9   vmid   np9   5.1525n
RA1_9  c2p9 np9   11.7374k
XU1_9  np9  nn9   vpos 0 vf9  OPA379
C2_9   c2p9 nn9   5.1525n
RA2_9  nn9  vf9   11.7374k
R2_9   nu29 vf9   100k
R3_9   vmid   nu29  100k
XU2_9  nu29 nn9   vpos 0 c2p9  OPA379
R4_9   vf9  da9   10k
R5_9   da9  ve9   47k
R6_9   vmid   np39  8.25k
D1_9   da9  dk9   Dbat54wt1
XU3_9  np39 da9   vpos 0 dk9  OPA379
D2_9   dk9  ve9   Dbat54wt1
C3_9   ve9  0       100n
DOR_9  ve9  v_or    Dbat54wt1
Ra_9   v_max  vt9   875.8000k
Rb_9   vt9  v_ref   124.2000k
Bcmp_9 vo9  0  V = 0.9 + 0.9*tanh(2e4*(v(ve9) - v(vt9)))

* ==== channel 10: f_c 2951 Hz, Q 5.60, alpha 0.2096 ====
R1_10   vin    np10   58.4621k
C1_10   vmid   np10   4.2972n
RA1_10  c2p10 np10   11.5666k
XU1_10  np10  nn10   vpos 0 vf10  OPA379
C2_10   c2p10 nn10   4.2972n
RA2_10  nn10  vf10   11.5666k
R2_10   nu210 vf10   100k
R3_10   vmid   nu210  100k
XU2_10  nu210 nn10   vpos 0 c2p10  OPA379
R4_10   vf10  da10   10k
R5_10   da10  ve10   47k
R6_10   vmid   np310  8.25k
D1_10   da10  dk10   Dbat54wt1
XU3_10  np310 da10   vpos 0 dk10  OPA379
D2_10   dk10  ve10   Dbat54wt1
C3_10   ve10  0       100n
DOR_10  ve10  v_or    Dbat54wt1
Ra_10   v_max  vt10   790.4000k
Rb_10   vt10  v_ref   209.6000k
Bcmp_10 vo10  0  V = 0.9 + 0.9*tanh(2e4*(v(ve10) - v(vt10)))

* ==== channel 11: f_c 3467 Hz, Q 5.78, alpha 0.2005 ====
R1_11   vin    np11   59.2962k
C1_11   vmid   np11   3.6059n
RA1_11  c2p11 np11   11.5905k
XU1_11  np11  nn11   vpos 0 vf11  OPA379
C2_11   c2p11 nn11   3.6059n
RA2_11  nn11  vf11   11.5905k
R2_11   nu211 vf11   100k
R3_11   vmid   nu211  100k
XU2_11  nu211 nn11   vpos 0 c2p11  OPA379
R4_11   vf11  da11   10k
R5_11   da11  ve11   47k
R6_11   vmid   np311  8.25k
D1_11   da11  dk11   Dbat54wt1
XU3_11  np311 da11   vpos 0 dk11  OPA379
D2_11   dk11  ve11   Dbat54wt1
C3_11   ve11  0       100n
DOR_11  ve11  v_or    Dbat54wt1
Ra_11   v_max  vt11   799.5000k
Rb_11   vt11  v_ref   200.5000k
Bcmp_11 vo11  0  V = 0.9 + 0.9*tanh(2e4*(v(ve11) - v(vt11)))

* ==== channel 12: f_c 4169 Hz, Q 5.95, alpha 0.1244 ====
R1_12   vin    np12   57.3973k
C1_12   vmid   np12   3.0408n
RA1_12  c2p12 np12   11.2365k
XU1_12  np12  nn12   vpos 0 vf12  OPA379
C2_12   c2p12 nn12   3.0408n
RA2_12  nn12  vf12   11.2365k
R2_12   nu212 vf12   100k
R3_12   vmid   nu212  100k
XU2_12  nu212 nn12   vpos 0 c2p12  OPA379
R4_12   vf12  da12   10k
R5_12   da12  ve12   47k
R6_12   vmid   np312  8.25k
D1_12   da12  dk12   Dbat54wt1
XU3_12  np312 da12   vpos 0 dk12  OPA379
D2_12   dk12  ve12   Dbat54wt1
C3_12   ve12  0       100n
DOR_12  ve12  v_or    Dbat54wt1
Ra_12   v_max  vt12   875.6000k
Rb_12   vt12  v_ref   124.4000k
Bcmp_12 vo12  0  V = 0.9 + 0.9*tanh(2e4*(v(ve12) - v(vt12)))

* ==== channel 13: f_c 4898 Hz, Q 6.11, alpha 0.0788 ====
R1_13   vin    np13   56.6026k
C1_13   vmid   np13   2.5747n
RA1_13  c2p13 np13   11.0979k
XU1_13  np13  nn13   vpos 0 vf13  OPA379
C2_13   c2p13 nn13   2.5747n
RA2_13  nn13  vf13   11.0979k
R2_13   nu213 vf13   100k
R3_13   vmid   nu213  100k
XU2_13  nu213 nn13   vpos 0 c2p13  OPA379
R4_13   vf13  da13   10k
R5_13   da13  ve13   47k
R6_13   vmid   np313  8.25k
D1_13   da13  dk13   Dbat54wt1
XU3_13  np313 da13   vpos 0 dk13  OPA379
D2_13   dk13  ve13   Dbat54wt1
C3_13   ve13  0       100n
DOR_13  ve13  v_or    Dbat54wt1
Ra_13   v_max  vt13   921.2000k
Rb_13   vt13  v_ref   78.8000k
Bcmp_13 vo13  0  V = 0.9 + 0.9*tanh(2e4*(v(ve13) - v(vt13)))

* ==== channel 14: f_c 5754 Hz, Q 6.27, alpha 0.0572 ====
R1_14   vin    np14   55.2220k
C1_14   vmid   np14   2.1875n
RA1_14  c2p14 np14   10.8882k
XU1_14  np14  nn14   vpos 0 vf14  OPA379
C2_14   c2p14 nn14   2.1875n
RA2_14  nn14  vf14   10.8882k
R2_14   nu214 vf14   100k
R3_14   vmid   nu214  100k
XU2_14  nu214 nn14   vpos 0 c2p14  OPA379
R4_14   vf14  da14   10k
R5_14   da14  ve14   47k
R6_14   vmid   np314  8.25k
D1_14   da14  dk14   Dbat54wt1
XU3_14  np314 da14   vpos 0 dk14  OPA379
D2_14   dk14  ve14   Dbat54wt1
C3_14   ve14  0       100n
DOR_14  ve14  v_or    Dbat54wt1
Ra_14   v_max  vt14   942.8000k
Rb_14   vt14  v_ref   57.2000k
Bcmp_14 vo14  0  V = 0.9 + 0.9*tanh(2e4*(v(ve14) - v(vt14)))

* ==== channel 15: f_c 6761 Hz, Q 6.45, alpha 0.3787 ====
R1_15   vin    np15   53.4096k
C1_15   vmid   np15   1.8637n
RA1_15  c2p15 np15   10.6107k
XU1_15  np15  nn15   vpos 0 vf15  OPA379
C2_15   c2p15 nn15   1.8637n
RA2_15  nn15  vf15   10.6107k
R2_15   nu215 vf15   100k
R3_15   vmid   nu215  100k
XU2_15  nu215 nn15   vpos 0 c2p15  OPA379
R4_15   vf15  da15   10k
R5_15   da15  ve15   47k
R6_15   vmid   np315  8.25k
D1_15   da15  dk15   Dbat54wt1
XU3_15  np315 da15   vpos 0 dk15  OPA379
D2_15   dk15  ve15   Dbat54wt1
C3_15   ve15  0       100n
DOR_15  ve15  v_or    Dbat54wt1
Ra_15   v_max  vt15   621.3000k
Rb_15   vt15  v_ref   378.7000k
Bcmp_15 vo15  0  V = 0.9 + 0.9*tanh(2e4*(v(ve15) - v(vt15)))

* ---- analyses -------------------------------------------------------
.control
op
echo ''
echo '--- shared nodes -------------------------------------'
print v(vin) v(v_max) v(v_ref)
echo ''
echo '--- per channel: envelope, threshold, comparator ------'
print v(ve0) v(vt0) v(vo0)
print v(ve1) v(vt1) v(vo1)
print v(ve2) v(vt2) v(vo2)
print v(ve3) v(vt3) v(vo3)
print v(ve4) v(vt4) v(vo4)
print v(ve5) v(vt5) v(vo5)
print v(ve6) v(vt6) v(vo6)
print v(ve7) v(vt7) v(vo7)
print v(ve8) v(vt8) v(vo8)
print v(ve9) v(vt9) v(vo9)
print v(ve10) v(vt10) v(vo10)
print v(ve11) v(vt11) v(vo11)
print v(ve12) v(vt12) v(vo12)
print v(ve13) v(vt13) v(vo13)
print v(ve14) v(vt14) v(vo14)
print v(ve15) v(vt15) v(vo15)

.endc

.end
